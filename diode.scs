// Point Netlist Generated on: Sep 26 17:43:06 2025
// Generated for: spectre
// Design Netlist Generated on: Sep 26 17:43:06 2025
// Design library name: bandgp
// Design cell name: diodechar
// Design view name: schematic
simulator lang=spectre
global 0
parameters I_branch=9.999999999999999e-05 temperature=27
include "/cad/library/TSMC/65/GP/oa_pdk/models/spectre/cor_dio_25.scs" section=tt_dio_25

// Library name: bandgp
// Cell name: diodechar
// View name: schematic
I3 (0 net1) isource dc=I_branch type=dc
D1 (net1 0) ndio_25 area=1e-10 pj=4e-05 m=1
simulatorOptions options psfversion="1.1.0" reltol=1e-3 vabstol=1e-6 \
    iabstol=1e-12 temp=27 tnom=27 scalem=1.0 scale=1.0 gmin=1e-12 rforce=1 \
    maxnotes=5 maxwarns=5 digits=5 cols=80 pivrel=1e-3 \
    sensfile="../psf/sens.output" checklimitdest=psf
dcOp dc write="spectre.dc" maxiters=150 maxsteps=10000 annotate=status
dcOpInfo info what=oppoint where=rawfile
dc dc param=temp start=-40 stop=125 step=10 oppoint=rawfile maxiters=150 \
    maxsteps=10000 annotate=status
modelParameter info what=models where=rawfile
element info what=inst where=rawfile
outputParameter info what=output where=rawfile
designParamVals info what=parameters where=rawfile
primitives info what=primitives where=rawfile
subckts info what=subckts where=rawfile
save net1
saveOptions options save=allpub
