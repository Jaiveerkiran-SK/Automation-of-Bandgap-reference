// Design: bandgp/ckt3
simulator lang=spectre
global 0
parameters vds=vol_ds vgs=vol_gs length=ch_len temperature=27
include "/cad/library/TSMC/65/GP/oa_pdk/models/spectre/cor_std_mos.scs" section=tt

// bandgp/ckt3/schematic
M0 (net2 net1 0 0) nch l=length w=200n m=1 nf=1
V1 (net1 0) vsource dc=vgs type=dc
V0 (net2 0) vsource dc=vds type=dc
simulatorOptions options temp=125
dcOp dc
dc dc param=vgs start=0 stop=vdd step=0.05
save M0:gmoverid M0:ids
