// Design: bandgp/ckt4
simulator lang=spectre
global 0
parameters VDD=vdd vds=vol_ds temperature=27 length=ch_len vgs=vol_gs
include "/cad/library/TSMC/65/GP/oa_pdk/models/spectre/cor_std_mos.scs" section=tt

// bandgp/ckt4/schematic
M0 (net2 net1 net3 net3) pch l=length w=200n m=1 nf=1
V5 (net2 0) vsource dc=vds type=dc
V3 (net3 0) vsource dc=VDD type=dc
V0 (net1 0) vsource dc=vgs type=dc
simulatorOptions options temp=125
dcOp dc
dc dc param=vgs start=0 stop=vol_vdd step=0.05
save M0:gmoverid M0:ids
